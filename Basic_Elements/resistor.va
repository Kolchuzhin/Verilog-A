// Verilog-A model https://verilogams.com/tutorials/vloga-intro.html
//
//     +       -
//  t1 o ----> o t2

`include "constants.vams"
`include "disciplines.vams"

module resistor (t1, t2);
electrical t1, t2;
parameter real r=1;
branch (t1, t2) res;

analog V(res) <+ r*I(res);
endmodule
